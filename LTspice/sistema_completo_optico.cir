* ============================================================================
* PROYECTO: Sistema de Comunicacion por Medios Opticos (EL2113)
* SIMULACION LTSPICE INTEGRADA (EN CONJUNTO): LAS 7 ETAPAS COMPLETAS
* AUTOR: Mario Cerdas y equipo de trabajo
* CUMPLIMIENTO: Punto 7 (pag. 6) y Requerimientos A.1 a Q.18
* ============================================================================
*
* Descripcion:
* Netlist equivalente al esquematico sistema_completo_optico.asc (mismos nodos
* y componentes). Sirve para correr la simulacion sin abrir el esquematico:
*   LTspice.exe -b sistema_completo_optico.cir
*   - Etapa 1: Patron de datos digital de 4 bits (b0, b1, b2, b3) = pines D8..D11.
*   - Etapa 2: Convertidor Digital-Analogico (Red pasiva R-2R + OpAmp 1A del LM358).
*   - Etapa 3: Etapa de Interfaz (Seguidor aislador con OpAmp 1B del LM358).
*   - Etapa 4: Generador Optico (Resistor 150 Ohms + LED Rojo 650 nm).
*   - Enlace Optico + Etapa 5: Fibra POF (45 cm) y Receptor LDR pasivo cuya
*     resistencia baja cuando aumenta la corriente (luz) del LED.
*   - Etapa 6: Generador de Onda Cuadrada (Temporizador NE555 en modo astable).
*   - Etapa 7: Buzzer Piezoelectrico Pasivo acoplado en AC.

.title Sistema Completo de Comunicacion por Medios Opticos (7 Etapas en Conjunto)

.param T=20m VOP=9

* --- Fuentes DC de Laboratorio (Req. P.17 y Q.18) ---
* VOP = 9 V para el LM358 (su salida llega solo hasta V+ - 1.5 V)
* VCC = 5 V para el NE555
V_OP VOP 0 {VOP}
V_CC VCC 0 5

* --- ETAPA 1: Patron de Datos de Prueba de 4 Bits (cada codigo dura T) ---
V_B0 B0 0 PULSE(0 5 {T}   10n 10n {T}   {2*T})
V_B1 B1 0 PULSE(0 5 {2*T} 10n 10n {2*T} {4*T})
V_B2 B2 0 PULSE(0 5 {4*T} 10n 10n {4*T} {8*T})
V_B3 B3 0 PULSE(0 5 {8*T} 10n 10n {8*T} {16*T})

* --- ETAPA 2: Convertidor Digital-Analogico (Red R-2R + OpAmp 1A - Req. E.5) ---
R_b0   B0    N001  20k
R_b1   B1    N002  20k
R_b2   B2    N003  20k
R_b3   B3    V_R2R 20k
R_h1   N002  N001  10k
R_h2   N003  N002  10k
R_h3   V_R2R N003  10k
R_term N001  0     20k
*      IN+   IN-   V+  V- OUT
XU1A   V_R2R V_DAC VOP 0  V_DAC LM358_SIMPLE

* --- ETAPA 3: Etapa de Interfaz con Amplificador Operacional (OpAmp 1B - Req. F.6) ---
XU1B   V_DAC V_INTERFAZ VOP 0 V_INTERFAZ LM358_SIMPLE

* --- ETAPA 4: Generador Optico (Resistor 150 Ohms + LED Rojo - Req. G.7 y H.8) ---
R_driver V_INTERFAZ N004 150
D_LED    N004 0 D_RED_650
.model D_RED_650 D(Is=1e-19 N=1.8 Rs=2 Cjo=20p Iave=30m Vpk=5 type=LED)

* --- ENLACE OPTICO (45 cm) + ETAPA 5: Receptor Optico Pasivo LDR (Req. I.9 y J.10) ---
* V(RLDR) contiene el valor de la LDR en ohm: 40 kOhm en oscuridad (LED apagado)
* y ~1.6 kOhm con el LED a ~19 mA. B_LDR se comporta como esa resistencia
* conectada entre DIS (pin 7) y THR (pines 6 y 2) del 555.
B_RLDR RLDR 0   V=1500+38500*exp(-max(I(D_LED),0)/0.003)
B_LDR  DIS  THR I=V(DIS,THR)/V(RLDR)

* --- ETAPA 6: Generador de Onda Cuadrada (Temporizador NE555 Astable - Req. K.11) ---
*     GND TRIG OUT     RST CV   THRS DIS VCC
XU2   0   THR  OUT_555 VCC N005 THR  DIS VCC NE555
R1    VCC DIS  1k
C1    THR 0    100n
C2    N005 0   10n

* --- ETAPA 7: Buzzer Piezoelectrico Pasivo con Acoplo AC (Req. L.12) ---
* R_buzzer = modelo simplificado de la impedancia del piezo pasivo
C_acoplo OUT_555 V_BUZZER 10u
R_buzzer V_BUZZER 0 1k

* --- Modelos ---
.lib LM358_simple.lib
.lib NE555.sub

* --- Simulacion Transitoria de las 7 Etapas en Conjunto (16 codigos x T) ---
.tran 0 {16*T} 0 5u startup

* --- Mediciones automaticas (ver resultados en el .log / SPICE Error Log) ---
.include mediciones_sistema.inc

.end
